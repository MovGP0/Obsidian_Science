* Functional CMOS 74181 model using reusable .SUBCKT logic gates.
* This is an active-high behavioral-equivalent gate-level implementation.
* It is not a transistor-accurate reconstruction of the original TTL silicon.

.MODEL CMOSN NMOS LEVEL=1 VTO=0.7 KP=120U GAMMA=0.4 PHI=0.7 LAMBDA=0.02
.MODEL CMOSP PMOS LEVEL=1 VTO=-0.7 KP=60U GAMMA=0.4 PHI=0.7 LAMBDA=0.02

.SUBCKT CMOS_INV A Y VDD VSS
MP1 Y A VDD VDD CMOSP L=1U W=2U
MN1 Y A VSS VSS CMOSN L=1U W=1U
.ENDS

.SUBCKT CMOS_NAND2 A B Y VDD VSS
MP1 Y A VDD VDD CMOSP L=1U W=2U
MP2 Y B VDD VDD CMOSP L=1U W=2U
MN1 Y A N1 VSS CMOSN L=1U W=1U
MN2 N1 B VSS VSS CMOSN L=1U W=1U
.ENDS

.SUBCKT CMOS_NOR2 A B Y VDD VSS
MP1 Y A N1 VDD CMOSP L=1U W=2U
MP2 N1 B VDD VDD CMOSP L=1U W=2U
MN1 Y A VSS VSS CMOSN L=1U W=1U
MN2 Y B VSS VSS CMOSN L=1U W=1U
.ENDS

.SUBCKT CMOS_AND2 A B Y VDD VSS
XU1 A B N1 VDD VSS CMOS_NAND2
XU2 N1 Y VDD VSS CMOS_INV
.ENDS

.SUBCKT CMOS_OR2 A B Y VDD VSS
XU1 A B N1 VDD VSS CMOS_NOR2
XU2 N1 Y VDD VSS CMOS_INV
.ENDS

.SUBCKT CMOS_XOR2 A B Y VDD VSS
XIA A NA VDD VSS CMOS_INV
XIB B NB VDD VSS CMOS_INV
XA1 NA B T1 VDD VSS CMOS_AND2
XA2 A NB T2 VDD VSS CMOS_AND2
XO1 T1 T2 Y VDD VSS CMOS_OR2
.ENDS

.SUBCKT CMOS_XNOR2 A B Y VDD VSS
XX1 A B N1 VDD VSS CMOS_XOR2
XI1 N1 Y VDD VSS CMOS_INV
.ENDS

.SUBCKT CMOS_AND3 A B C Y VDD VSS
XA1 A B N1 VDD VSS CMOS_AND2
XA2 N1 C Y VDD VSS CMOS_AND2
.ENDS

.SUBCKT CMOS_AND4 A B C D Y VDD VSS
XA1 A B N1 VDD VSS CMOS_AND2
XA2 C D N2 VDD VSS CMOS_AND2
XA3 N1 N2 Y VDD VSS CMOS_AND2
.ENDS

.SUBCKT CMOS_OR3 A B C Y VDD VSS
XO1 A B N1 VDD VSS CMOS_OR2
XO2 N1 C Y VDD VSS CMOS_OR2
.ENDS

.SUBCKT CMOS_OR4 A B C D Y VDD VSS
XO1 A B N1 VDD VSS CMOS_OR2
XO2 C D N2 VDD VSS CMOS_OR2
XO3 N1 N2 Y VDD VSS CMOS_OR2
.ENDS

.SUBCKT CMOS_MUX2 D0 D1 S Y VDD VSS
XI1 S NS VDD VSS CMOS_INV
XA1 D0 NS T0 VDD VSS CMOS_AND2
XA2 D1 S  T1 VDD VSS CMOS_AND2
XO1 T0 T1 Y VDD VSS CMOS_OR2
.ENDS

.SUBCKT CMOS_MUX4 D0 D1 D2 D3 S0 S1 Y VDD VSS
XM1 D0 D1 S0 N0 VDD VSS CMOS_MUX2
XM2 D2 D3 S0 N1 VDD VSS CMOS_MUX2
XM3 N0 N1 S1 Y VDD VSS CMOS_MUX2
.ENDS

.SUBCKT CMOS_MUX16
+ D0 D1 D2 D3 D4 D5 D6 D7 D8 D9 D10 D11 D12 D13 D14 D15
+ S0 S1 S2 S3
+ Y VDD VSS
XM1 D0 D1 D2 D3   S0 S1 N0 VDD VSS CMOS_MUX4
XM2 D4 D5 D6 D7   S0 S1 N1 VDD VSS CMOS_MUX4
XM3 D8 D9 D10 D11 S0 S1 N2 VDD VSS CMOS_MUX4
XM4 D12 D13 D14 D15 S0 S1 N3 VDD VSS CMOS_MUX4
XM5 N0 N1 N2 N3 S2 S3 Y VDD VSS CMOS_MUX4
.ENDS

.SUBCKT CMOS_FULLADD A B CIN SUM COUT VDD VSS
XX1 A B   X1 VDD VSS CMOS_XOR2
XX2 X1 CIN SUM VDD VSS CMOS_XOR2
XA1 A B   A1 VDD VSS CMOS_AND2
XA2 A CIN A2 VDD VSS CMOS_AND2
XA3 B CIN A3 VDD VSS CMOS_AND2
XO1 A1 A2 O1 VDD VSS CMOS_OR2
XO2 O1 A3 COUT VDD VSS CMOS_OR2
.ENDS

.SUBCKT CMOS_ADD4
+ A0 A1 A2 A3
+ B0 B1 B2 B3
+ CIN
+ S0 S1 S2 S3
+ COUT
+ VDD VSS
XFA0 A0 B0 CIN S0 C1C VDD VSS CMOS_FULLADD
XFA1 A1 B1 C1C S1 C2C VDD VSS CMOS_FULLADD
XFA2 A2 B2 C2C S2 C3C VDD VSS CMOS_FULLADD
XFA3 A3 B3 C3C S3 COUT VDD VSS CMOS_FULLADD
.ENDS

.SUBCKT CMOS_74181
+ A0 A1 A2 A3
+ B0 B1 B2 B3
+ S0 S1 S2 S3
+ M CIN
+ F0 F1 F2 F3
+ COUT P G AEQB
+ VDD VSS

* Complements of operands.
XNA0 A0 NA0 VDD VSS CMOS_INV
XNA1 A1 NA1 VDD VSS CMOS_INV
XNA2 A2 NA2 VDD VSS CMOS_INV
XNA3 A3 NA3 VDD VSS CMOS_INV
XNB0 B0 NB0 VDD VSS CMOS_INV
XNB1 B1 NB1 VDD VSS CMOS_INV
XNB2 B2 NB2 VDD VSS CMOS_INV
XNB3 B3 NB3 VDD VSS CMOS_INV

* Per-bit helper terms.
XAAB0 A0 B0 AAB0 VDD VSS CMOS_AND2
XAAB1 A1 B1 AAB1 VDD VSS CMOS_AND2
XAAB2 A2 B2 AAB2 VDD VSS CMOS_AND2
XAAB3 A3 B3 AAB3 VDD VSS CMOS_AND2

XAANB0 A0 NB0 AANB0 VDD VSS CMOS_AND2
XAANB1 A1 NB1 AANB1 VDD VSS CMOS_AND2
XAANB2 A2 NB2 AANB2 VDD VSS CMOS_AND2
XAANB3 A3 NB3 AANB3 VDD VSS CMOS_AND2

XOAB0 A0 B0 OAB0 VDD VSS CMOS_OR2
XOAB1 A1 B1 OAB1 VDD VSS CMOS_OR2
XOAB2 A2 B2 OAB2 VDD VSS CMOS_OR2
XOAB3 A3 B3 OAB3 VDD VSS CMOS_OR2

XOANB0 A0 NB0 OANB0 VDD VSS CMOS_OR2
XOANB1 A1 NB1 OANB1 VDD VSS CMOS_OR2
XOANB2 A2 NB2 OANB2 VDD VSS CMOS_OR2
XOANB3 A3 NB3 OANB3 VDD VSS CMOS_OR2

XXOR0 A0 B0 LX6_0 VDD VSS CMOS_XOR2
XXOR1 A1 B1 LX6_1 VDD VSS CMOS_XOR2
XXOR2 A2 B2 LX6_2 VDD VSS CMOS_XOR2
XXOR3 A3 B3 LX6_3 VDD VSS CMOS_XOR2

XXNOR0 A0 B0 LX9_0 VDD VSS CMOS_XNOR2
XXNOR1 A1 B1 LX9_1 VDD VSS CMOS_XNOR2
XXNOR2 A2 B2 LX9_2 VDD VSS CMOS_XNOR2
XXNOR3 A3 B3 LX9_3 VDD VSS CMOS_XNOR2

XNOR0 A0 B0 LX1_0 VDD VSS CMOS_NOR2
XNOR1 A1 B1 LX1_1 VDD VSS CMOS_NOR2
XNOR2 A2 B2 LX1_2 VDD VSS CMOS_NOR2
XNOR3 A3 B3 LX1_3 VDD VSS CMOS_NOR2

XNAND0 A0 B0 LX4_0 VDD VSS CMOS_NAND2
XNAND1 A1 B1 LX4_1 VDD VSS CMOS_NAND2
XNAND2 A2 B2 LX4_2 VDD VSS CMOS_NAND2
XNAND3 A3 B3 LX4_3 VDD VSS CMOS_NAND2

XO8_0 NA0 B0 LX8_0 VDD VSS CMOS_OR2
XO8_1 NA1 B1 LX8_1 VDD VSS CMOS_OR2
XO8_2 NA2 B2 LX8_2 VDD VSS CMOS_OR2
XO8_3 NA3 B3 LX8_3 VDD VSS CMOS_OR2

XO13_0 A0 NB0 LX13_0 VDD VSS CMOS_OR2
XO13_1 A1 NB1 LX13_1 VDD VSS CMOS_OR2
XO13_2 A2 NB2 LX13_2 VDD VSS CMOS_OR2
XO13_3 A3 NB3 LX13_3 VDD VSS CMOS_OR2

XO14_0 A0 B0 LX14_0 VDD VSS CMOS_OR2
XO14_1 A1 B1 LX14_1 VDD VSS CMOS_OR2
XO14_2 A2 B2 LX14_2 VDD VSS CMOS_OR2
XO14_3 A3 B3 LX14_3 VDD VSS CMOS_OR2

* Logic mode outputs, active-high form.
XMLOG0_0
+ NA0 LX1_0 AAB0 VSS LX4_0 NB0 LX6_0 AANB0
+ LX8_0 LX9_0 B0 AAB0 VDD LX13_0 LX14_0 A0
+ S0 S1 S2 S3
+ LOG0 VDD VSS
+ CMOS_MUX16
XMLOG1_0
+ NA1 LX1_1 AAB1 VSS LX4_1 NB1 LX6_1 AANB1
+ LX8_1 LX9_1 B1 AAB1 VDD LX13_1 LX14_1 A1
+ S0 S1 S2 S3
+ LOG1 VDD VSS
+ CMOS_MUX16
XMLOG2_0
+ NA2 LX1_2 AAB2 VSS LX4_2 NB2 LX6_2 AANB2
+ LX8_2 LX9_2 B2 AAB2 VDD LX13_2 LX14_2 A2
+ S0 S1 S2 S3
+ LOG2 VDD VSS
+ CMOS_MUX16
XMLOG3_0
+ NA3 LX1_3 AAB3 VSS LX4_3 NB3 LX6_3 AANB3
+ LX8_3 LX9_3 B3 AAB3 VDD LX13_3 LX14_3 A3
+ S0 S1 S2 S3
+ LOG3 VDD VSS
+ CMOS_MUX16

* Arithmetic base results for CIN = 0.
* 0: A
EAB0_0 AB0_0 VSS VALUE = { V(A0,VSS) }
EAB0_1 AB0_1 VSS VALUE = { V(A1,VSS) }
EAB0_2 AB0_2 VSS VALUE = { V(A2,VSS) }
EAB0_3 AB0_3 VSS VALUE = { V(A3,VSS) }
EAC0 AC0_0 VSS VALUE = { 0 }

* 1: A + B
XADD1 A0 A1 A2 A3 B0 B1 B2 B3 VSS AB1_0 AB1_1 AB1_2 AB1_3 AC1_0 VDD VSS CMOS_ADD4

* 2: A + NOT B
XADD2 A0 A1 A2 A3 NB0 NB1 NB2 NB3 VSS AB2_0 AB2_1 AB2_2 AB2_3 AC2_0 VDD VSS CMOS_ADD4

* 3: -1
EAB3_0 AB3_0 VSS VALUE = { V(VDD,VSS) }
EAB3_1 AB3_1 VSS VALUE = { V(VDD,VSS) }
EAB3_2 AB3_2 VSS VALUE = { V(VDD,VSS) }
EAB3_3 AB3_3 VSS VALUE = { V(VDD,VSS) }
EAC3 AC3_0 VSS VALUE = { 0 }

* 4: A + A AND NOT B
XADD4 A0 A1 A2 A3 AANB0 AANB1 AANB2 AANB3 VSS AB4_0 AB4_1 AB4_2 AB4_3 AC4_0 VDD VSS CMOS_ADD4

* 5: (A OR B) + A AND NOT B
XADD5 OAB0 OAB1 OAB2 OAB3 AANB0 AANB1 AANB2 AANB3 VSS AB5_0 AB5_1 AB5_2 AB5_3 AC5_0 VDD VSS CMOS_ADD4

* 6: A - B - 1 = A + NOT B
EAB6_0 AB6_0 VSS VALUE = { V(AB2_0,VSS) }
EAB6_1 AB6_1 VSS VALUE = { V(AB2_1,VSS) }
EAB6_2 AB6_2 VSS VALUE = { V(AB2_2,VSS) }
EAB6_3 AB6_3 VSS VALUE = { V(AB2_3,VSS) }
EAC6 AC6_0 VSS VALUE = { V(AC2_0,VSS) }

* 7: (A AND B) - 1
XADD7 AAB0 AAB1 AAB2 AAB3 VDD VDD VDD VDD VSS AB7_0 AB7_1 AB7_2 AB7_3 AC7_0 VDD VSS CMOS_ADD4

* 8: A + A AND B
XADD8 A0 A1 A2 A3 AAB0 AAB1 AAB2 AAB3 VSS AB8_0 AB8_1 AB8_2 AB8_3 AC8_0 VDD VSS CMOS_ADD4

* 9: A + B
EAB9_0 AB9_0 VSS VALUE = { V(AB1_0,VSS) }
EAB9_1 AB9_1 VSS VALUE = { V(AB1_1,VSS) }
EAB9_2 AB9_2 VSS VALUE = { V(AB1_2,VSS) }
EAB9_3 AB9_3 VSS VALUE = { V(AB1_3,VSS) }
EAC9 AC9_0 VSS VALUE = { V(AC1_0,VSS) }

* 10: (A OR NOT B) + A AND B
XADD10 OANB0 OANB1 OANB2 OANB3 AAB0 AAB1 AAB2 AAB3 VSS AB10_0 AB10_1 AB10_2 AB10_3 AC10_0 VDD VSS CMOS_ADD4

* 11: (A AND B) - 1
EAB11_0 AB11_0 VSS VALUE = { V(AB7_0,VSS) }
EAB11_1 AB11_1 VSS VALUE = { V(AB7_1,VSS) }
EAB11_2 AB11_2 VSS VALUE = { V(AB7_2,VSS) }
EAB11_3 AB11_3 VSS VALUE = { V(AB7_3,VSS) }
EAC11 AC11_0 VSS VALUE = { V(AC7_0,VSS) }

* 12: A + A
XADD12 A0 A1 A2 A3 A0 A1 A2 A3 VSS AB12_0 AB12_1 AB12_2 AB12_3 AC12_0 VDD VSS CMOS_ADD4

* 13: (A OR B) + A
XADD13 OAB0 OAB1 OAB2 OAB3 A0 A1 A2 A3 VSS AB13_0 AB13_1 AB13_2 AB13_3 AC13_0 VDD VSS CMOS_ADD4

* 14: (A OR NOT B) + A
XADD14 OANB0 OANB1 OANB2 OANB3 A0 A1 A2 A3 VSS AB14_0 AB14_1 AB14_2 AB14_3 AC14_0 VDD VSS CMOS_ADD4

* 15: A - 1
XADD15 A0 A1 A2 A3 VDD VDD VDD VDD VSS AB15_0 AB15_1 AB15_2 AB15_3 AC15_0 VDD VSS CMOS_ADD4

* Select arithmetic base bits and carry-out for CIN = 0.
XMB0
+ AB0_0 AB1_0 AB2_0 AB3_0 AB4_0 AB5_0 AB6_0 AB7_0 AB8_0 AB9_0 AB10_0 AB11_0 AB12_0 AB13_0 AB14_0 AB15_0
+ S0 S1 S2 S3
+ BASE0 VDD VSS
+ CMOS_MUX16
XMB1
+ AB0_1 AB1_1 AB2_1 AB3_1 AB4_1 AB5_1 AB6_1 AB7_1 AB8_1 AB9_1 AB10_1 AB11_1 AB12_1 AB13_1 AB14_1 AB15_1
+ S0 S1 S2 S3
+ BASE1 VDD VSS
+ CMOS_MUX16
XMB2
+ AB0_2 AB1_2 AB2_2 AB3_2 AB4_2 AB5_2 AB6_2 AB7_2 AB8_2 AB9_2 AB10_2 AB11_2 AB12_2 AB13_2 AB14_2 AB15_2
+ S0 S1 S2 S3
+ BASE2 VDD VSS
+ CMOS_MUX16
XMB3
+ AB0_3 AB1_3 AB2_3 AB3_3 AB4_3 AB5_3 AB6_3 AB7_3 AB8_3 AB9_3 AB10_3 AB11_3 AB12_3 AB13_3 AB14_3 AB15_3
+ S0 S1 S2 S3
+ BASE3 VDD VSS
+ CMOS_MUX16
XMBC
+ AC0_0 AC1_0 AC2_0 AC3_0 AC4_0 AC5_0 AC6_0 AC7_0 AC8_0 AC9_0 AC10_0 AC11_0 AC12_0 AC13_0 AC14_0 AC15_0
+ S0 S1 S2 S3
+ BASEC0 VDD VSS
+ CMOS_MUX16

* Add the user carry-in to the selected arithmetic base result.
XADDINC BASE0 BASE1 BASE2 BASE3 VSS VSS VSS VSS CIN AR0 AR1 AR2 AR3 ARCY VDD VSS CMOS_ADD4
XORC BASEC0 ARCY ACOUT_RAW VDD VSS CMOS_OR2
XINVBC0 BASEC0 NBASEC0 VDD VSS CMOS_INV
XANDP NBASEC0 ARCY P_RAW VDD VSS CMOS_AND2

* Logic mode forces arithmetic carry helper outputs low.
XMCOUT ACOUT_RAW VSS M COUT VDD VSS CMOS_MUX2
XMP    P_RAW     VSS M P    VDD VSS CMOS_MUX2
XMG    BASEC0    VSS M G    VDD VSS CMOS_MUX2

* Final F outputs.
XMF0 AR0 LOG0 M F0 VDD VSS CMOS_MUX2
XMF1 AR1 LOG1 M F1 VDD VSS CMOS_MUX2
XMF2 AR2 LOG2 M F2 VDD VSS CMOS_MUX2
XMF3 AR3 LOG3 M F3 VDD VSS CMOS_MUX2

* A = B output is decoded from the function outputs as in the original part.
XAE1 F0 F1 AEF01 VDD VSS CMOS_AND2
XAE2 F2 F3 AEF23 VDD VSS CMOS_AND2
XAE3 AEF01 AEF23 AEQB VDD VSS CMOS_AND2
.ENDS
